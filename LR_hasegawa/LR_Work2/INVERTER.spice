** sch_path: /home/tororo/LR/LR_hasegawa/LR_Work2/symbol/INVERTER.sch
**.subckt INVERTER IN OUT
*.opin OUT
*.ipin IN
M6 OUT IN VDD VDD pch w=3u l=0.35u as=5.6p ps=9u ad=5.6p pd=9u m=1
M8 OUT IN GND GND nch w=1u l=0.35u as=2.8p ps=5.5u ad=2.8p pd=5.5u m=1
**.ends
.GLOBAL VDD
.GLOBAL GND
.end
