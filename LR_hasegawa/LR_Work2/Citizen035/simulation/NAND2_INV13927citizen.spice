** sch_path: /home/tororo009/work/LR-hasegawa/LR_hasegawa/LR_Work2/Citizen035/NAND2_citizen#2.sch
.subckt NAND2_INV13927citizen IN1 IN2 OUT VDD VSS
*.iopin OUT
*.iopin IN2
*.iopin IN1
x1 net4 net1 VDD VSS INVERTER_Citizen
x2 net1 net2 VDD VSS INVERTER3_Citizen
x3 net2 net3 VDD VSS INVERTER9_Citizen
x4 net3 OUT VDD VSS INVERTER27_Citizen
x5 net4 IN1 IN2 VDD VSS NAND2_Citizen
**** begin user architecture code

blabla

VVDD VDD 0 DC 3.3
VVSS VSS 0 DC 0

VIN1 IN1 0 pulse(0 3.3 100n 1n 1n 100n 200n)
VIN2 IN2 0 pulse(0 3.3 100n 1n 1n 100n 200n)

*Cload Q 0 1p
*Cload XQ 0 1p

.control
tran 1n 1000n

write buffer_citizen#1.raw

.endc

**** end user architecture code
.ends

* expanding   symbol:  work/LR-hasegawa/LR_hasegawa/LR_Work2/Citizen035/INVERTER_Citizen.sym # of pins=2
** sym_path: /home/tororo009/work/LR-hasegawa/LR_hasegawa/LR_Work2/Citizen035/INVERTER_Citizen.sym
** sch_path: /home/tororo009/work/LR-hasegawa/LR_hasegawa/LR_Work2/Citizen035/INVERTER_Citizen.sch
.subckt INVERTER_Citizen IN OUT VDD VSS
*.iopin OUT
*.iopin IN
M1 OUT IN VSS VSS NMOS w=1.2u l=0.4u as=0 ps=0 ad=0 pd=0 m=1
M2 OUT IN VDD VDD PMOS w=3.6u l=0.4u as=0 ps=0 ad=0 pd=0 m=1
.ends

* expanding   symbol:  work/LR-hasegawa/LR_hasegawa/LR_Work2/Citizen035/INVERTER3_Citizen.sym # of pins=2
** sym_path: /home/tororo009/work/LR-hasegawa/LR_hasegawa/LR_Work2/Citizen035/INVERTER3_Citizen.sym
** sch_path: /home/tororo009/work/LR-hasegawa/LR_hasegawa/LR_Work2/Citizen035/INVERTER3_Citizen.sch
.subckt INVERTER3_Citizen IN OUT VDD VSS
*.iopin OUT
*.iopin IN
X1 IN OUT VDD VSS INVERTER_Citizen
X2 IN OUT VDD VSS INVERTER_Citizen
X3 IN OUT VDD VSS INVERTER_Citizen
*M1 OUT IN VSS VSS NMOS w=1.2u l=0.4u as=0 ps=0 ad=0 pd=0 m=3
*M2 OUT IN VDD VDD PMOS w=3.6u l=0.4u as=0 ps=0 ad=0 pd=0 m=3
.ends

* expanding   symbol:  work/LR-hasegawa/LR_hasegawa/LR_Work2/Citizen035/INVERTER9_Citizen.sym # of pins=2
** sym_path: /home/tororo009/work/LR-hasegawa/LR_hasegawa/LR_Work2/Citizen035/INVERTER9_Citizen.sym
** sch_path: /home/tororo009/work/LR-hasegawa/LR_hasegawa/LR_Work2/Citizen035/INVERTER9_Citizen.sch
.subckt INVERTER9_Citizen IN OUT VDD VSS
*.iopin OUT
*.iopin IN
X1 IN OUT VDD VSS INVERTER3_Citizen
X2 IN OUT VDD VSS INVERTER3_Citizen
X3 IN OUT VDD VSS INVERTER3_Citizen
.ends

* expanding   symbol:  work/LR-hasegawa/LR_hasegawa/LR_Work2/Citizen035/INVERTER27_Citizen.sym # of pins=2
** sym_path: /home/tororo009/work/LR-hasegawa/LR_hasegawa/LR_Work2/Citizen035/INVERTER27_Citizen.sym
** sch_path: /home/tororo009/work/LR-hasegawa/LR_hasegawa/LR_Work2/Citizen035/INVERTER27_Citizen.sch
.subckt INVERTER27_Citizen IN OUT VDD VSS
*.iopin IN
*.iopin OUT
X1 IN OUT VDD VSS INVERTER9_Citizen
X2 IN OUT VDD VSS INVERTER9_Citizen
X3 IN OUT VDD VSS INVERTER9_Citizen
.ends

* expanding   symbol:  work/LR-hasegawa/LR_hasegawa/LR_Work2/Citizen035/NAND2_Citizen.sym # of pins=3
** sym_path: /home/tororo009/work/LR-hasegawa/LR_hasegawa/LR_Work2/Citizen035/NAND2_Citizen.sym
** sch_path: /home/tororo009/work/LR-hasegawa/LR_hasegawa/LR_Work2/Citizen035/NAND2_Citizen.sch
.subckt NAND2_Citizen OUT IN1 IN2 VDD VSS
*.iopin OUT
*.iopin IN1
*.iopin IN2
M5 net1 IN2 VSS VSS NMOS w=2.4u l=0.4u as=0 ps=0 ad=0 pd=0 m=1
M6 OUT IN1 net1 VSS NMOS w=2.4u l=0.4u as=0 ps=0 ad=0 pd=0 m=1
M7 OUT IN2 VDD VDD PMOS w=3.6u l=0.4u as=0 ps=0 ad=0 pd=0 m=1
M8 OUT IN1 VDD VDD PMOS w=3.6u l=0.4u as=0 ps=0 ad=0 pd=0 m=1
.ends

.GLOBAL VDD

.end
