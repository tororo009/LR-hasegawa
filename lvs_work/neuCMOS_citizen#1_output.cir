* Created by KLayout

* cell invbuf
.SUBCKT invbuf
* net 1 IN1,IN2
* net 2 VDD
* net 3 IN
* net 7 OUT
* net 8 GND
* cell instance $3 r0 *1 -5.16,0.9
X$3 3 8 2 1 8 9 INV_Citizen
* cell instance $5 r0 *1 0.04,0.9
X$5 4 8 2 3 8 9 INV_Citizen
* cell instance $7 r0 *1 -11.53,0.22
X$7 6 5 8 8 8 8 8 8 8 8 8 8 2 2 2 2 2 2 2 2 2 9 INV_Citizen9
* cell instance $8 r0 *1 -36.9,-0.02
X$8 7 6 8 8 8 8 8 8 8 8 8 8 8 8 8 8 8 8 8 8 8 8 8 8 8 8 8 8 8 8 2 2 2 2 2 2 2 2
+ 2 2 2 2 2 2 2 2 2 2 2 2 2 2 2 2 2 2 2 9 INV_Citizen27
* cell instance $9 r0 *1 -4.69,0.75
X$9 5 4 8 8 8 8 2 2 2 9 INV_Citizen3
.ENDS invbuf

* cell INV_Citizen27
* pin
* pin
* pin SUBSTRATE
* pin
* pin
* pin
* pin
* pin
* pin
* pin
* pin
* pin
* pin
* pin
* pin
* pin
* pin
* pin
* pin
* pin
* pin
* pin
* pin
* pin
* pin
* pin
* pin
* pin
* pin
* pin
* pin
* pin
* pin
* pin
* pin
* pin
* pin
* pin
* pin
* pin
* pin
* pin
* pin
* pin
* pin
* pin
* pin
* pin
* pin
* pin
* pin
* pin
* pin
* pin
* pin
* pin
* pin
* pin
.SUBCKT INV_Citizen27 1 2 3 4 5 6 7 8 9 10 11 12 13 14 15 16 17 18 19 20 21 22
+ 23 24 25 26 27 28 29 30 31 32 33 34 35 36 37 38 39 40 41 42 43 44 45 46 47 48
+ 49 50 51 52 53 54 55 56 57 58
* net 3 SUBSTRATE
* cell instance $1 r0 *1 72.17,0.24
X$1 1 2 3 5 14 23 8 17 26 11 20 29 56 53 50 47 44 41 38 35 32 58 INV_Citizen9
* cell instance $2 r0 *1 118.97,0.24
X$2 1 2 3 4 13 22 7 16 25 10 19 28 55 52 49 46 43 40 37 34 31 58 INV_Citizen9
* cell instance $3 r0 *1 165.77,0.24
X$3 1 2 3 6 15 24 9 18 27 12 21 30 57 54 51 48 45 42 39 36 33 58 INV_Citizen9
.ENDS INV_Citizen27

* cell INV_Citizen
* pin
* pin
* pin
* pin
* pin SUBSTRATE
* pin
.SUBCKT INV_Citizen 1 2 3 4 5 6
* net 5 SUBSTRATE
* cell instance $1 r270 *1 37.24,14.13
X$1 1 3 4 5 Pch
* device instance $1 r0 *1 39.59,2.48 NMOS
M$1 1 4 2 6 NMOS L=0.4U W=1.2U AS=1.62P AD=1.62P PS=5.1U PD=5.1U
.ENDS INV_Citizen

* cell INV_Citizen9
* pin
* pin
* pin SUBSTRATE
* pin
* pin
* pin
* pin
* pin
* pin
* pin
* pin
* pin
* pin
* pin
* pin
* pin
* pin
* pin
* pin
* pin
* pin
* pin
.SUBCKT INV_Citizen9 1 2 3 4 5 6 7 8 9 10 11 12 13 14 15 16 17 18 19 20 21 22
* net 3 SUBSTRATE
* cell instance $1 r0 *1 53.64,0.53
X$1 1 2 3 6 9 12 21 18 15 22 INV_Citizen3
* cell instance $2 r0 *1 22.44,0.53
X$2 1 2 3 4 7 10 19 16 13 22 INV_Citizen3
* cell instance $3 r0 *1 38.04,0.53
X$3 1 2 3 5 8 11 20 17 14 22 INV_Citizen3
.ENDS INV_Citizen9

* cell INV_Citizen3
* pin
* pin
* pin SUBSTRATE
* pin
* pin
* pin
* pin
* pin
* pin
* pin
.SUBCKT INV_Citizen3 1 2 3 4 5 6 7 8 9 10
* net 3 SUBSTRATE
* cell instance $1 r0 *1 7.18,-0.02
X$1 1 6 9 2 3 10 INV_Citizen$1
* cell instance $2 r0 *1 17.58,-0.02
X$2 1 4 7 2 3 10 INV_Citizen$1
* cell instance $3 r0 *1 12.38,-0.02
X$3 1 5 8 2 3 10 INV_Citizen$1
.ENDS INV_Citizen3

* cell INV_Citizen$1
* pin
* pin
* pin
* pin
* pin SUBSTRATE
* pin
.SUBCKT INV_Citizen$1 1 2 3 4 5 6
* net 5 SUBSTRATE
* cell instance $1 r270 *1 39.99,14.3
X$1 1 3 4 5 Pch
* device instance $1 r0 *1 42.34,2.65 NMOS
M$1 1 4 2 6 NMOS L=0.4U W=1.2U AS=1.62P AD=1.62P PS=5.1U PD=5.1U
.ENDS INV_Citizen$1

* cell Pch
* pin
* pin
* pin
* pin SUBSTRATE
.SUBCKT Pch 1 2 3 4
* net 4 SUBSTRATE
* device instance $1 r0 *1 1.55,2.3 PMOS
M$1 2 3 1 4 PMOS L=0.4U W=1.2U AS=1.62P AD=0.9P PS=5.1U PD=2.7U
* device instance $2 r0 *1 3.45,2.3 PMOS
M$2 1 3 2 4 PMOS L=0.4U W=1.2U AS=0.9P AD=0.9P PS=2.7U PD=2.7U
* device instance $3 r0 *1 5.35,2.3 PMOS
M$3 2 3 1 4 PMOS L=0.4U W=1.2U AS=0.9P AD=1.62P PS=2.7U PD=5.1U
.ENDS Pch
