* Created by KLayout

* cell invbuf
* pin IN1
* pin IN2
* pin GND
* pin IN
* pin OUT
* pin VDD
.SUBCKT invbuf 1 2 4 5 9 10
* net 1 IN1
* net 2 IN2
* net 4 GND
* net 5 IN
* net 9 OUT
* net 10 VDD
* device instance $1 r0 *1 21.49,32.19 PIP_cap
C$1 3 1 1.02e-13 PIP_cap
* device instance $2 r0 *1 21.48,17.46 PIP_cap
C$2 3 2 1.02e-13 PIP_cap
* device instance $3 r0 *1 21.46,2.71 PIP_cap
C$3 3 4 1.02e-13 PIP_cap
* device instance $4 r0 *1 34.43,3.38 NMOS
M$4 5 3 4 4 NMOS L=0.4U W=1.2U AS=1.62P AD=1.62P PS=5.1U PD=5.1U
* device instance $5 r0 *1 39.63,3.38 NMOS
M$5 6 5 4 4 NMOS L=0.4U W=1.2U AS=1.62P AD=1.62P PS=5.1U PD=5.1U
* device instance $6 r270 *1 34.38,13.48 PMOS
M$6 10 3 5 10 PMOS L=0.4U W=3.6U AS=3.42P AD=3.42P PS=10.5U PD=10.5U
* device instance $9 r270 *1 39.58,13.48 PMOS
M$9 10 5 6 10 PMOS L=0.4U W=3.6U AS=3.42P AD=3.42P PS=10.5U PD=10.5U
* device instance $12 r0 *1 44.83,3.38 NMOS
M$12 7 6 4 4 NMOS L=0.4U W=3.6U AS=4.86P AD=4.86P PS=15.3U PD=15.3U
* device instance $15 r0 *1 91.63,3.38 NMOS
M$15 8 7 4 4 NMOS L=0.4U W=10.8U AS=14.58P AD=14.58P PS=45.9U PD=45.9U
* device instance $24 r0 *1 138.43,3.38 NMOS
M$24 9 8 4 4 NMOS L=0.4U W=32.4U AS=43.74P AD=43.74P PS=137.7U PD=137.7U
* device instance $51 r270 *1 44.78,13.48 PMOS
M$51 10 6 7 10 PMOS L=0.4U W=10.8U AS=10.26P AD=10.26P PS=31.5U PD=31.5U
* device instance $60 r270 *1 91.58,13.48 PMOS
M$60 10 7 8 10 PMOS L=0.4U W=32.4U AS=30.78P AD=30.78P PS=94.5U PD=94.5U
* device instance $87 r270 *1 138.38,13.48 PMOS
M$87 10 8 9 10 PMOS L=0.4U W=97.2U AS=92.34P AD=92.34P PS=283.5U PD=283.5U
.ENDS invbuf
